* Full-wave bridge rectifier with smoothing cap and load
* Matches benchmarking/fullwave_rect_vs_ngspice.py
*
* Nodes: inp, inn, outp, outn, 0(GND)
* Output: v(outp,outn) — full-wave rectified voltage

.model d1n4007 d is=76.9p rs=42.0m bv=1.00k ibv=5.00u cjo=26.5p m=0.333 n=1.45

vs inp inn 0 sin 0.0 20 50.0

d1 inp outp d1n4007
d2 outn inp d1n4007
d3 inn outp d1n4007
d4 outn inn d1n4007
cl outp outn 100u
rl outp outn 1k
rgnd1 inn 0 1meg
rgnd2 outn 0 1meg

.options klu method=gear maxord=2

.control
  tran 1u 1 0 1u
  wrdata /tmp/ngspice_fullwave_rect.dat v(outp) v(outn) v(outp,outn)
  set noaskquit
  quit
.endc

.end
