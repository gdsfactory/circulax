* Diode cascade (Cockcroft-Walton x2) benchmark
* Matches benchmarking/diode_cascade_vs_ngspice.py
*
* Nodes: 0(GND), a, 1, 2, 10, 20
* Output: v(20) — 4x voltage multiplier peak

.model D1N4007 D IS=76.9p RS=42.0m BV=1.00k IBV=5.00u CJO=26.5p M=0.333 N=1.45

.param c=100n

vs a 0 dc=0 sin 0 50 100k
r1 a 1 r=0.01
c1 1 2 c={c}
d1 0 1 D1N4007
c2 0 10 c={c}
d2 1 10 D1N4007
c3 1 2  c={c}
d3 10 2 D1N4007
c4 10 20 c={c}
d4 2 20 D1N4007

.options klu method=gear maxord=2

.control
  tran 0.01u 5m 0 0.01u
  wrdata /tmp/ngspice_diode_cascade.dat v(1) v(10) v(20)
  set noaskquit
  quit
.endc

.end
